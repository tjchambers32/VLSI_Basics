simulator( 'spectre )
design(	 "/auto/fsg/lhsiao/cadence/simulation/tutorial3/spectre/config/netlist/netlist")
resultsDir( "/auto/fsg/lhsiao/cadence/simulation/tutorial3/spectre/config" )
modelFile(
    '("/auto/ee2/Cadence/local/designkits/BYU/lib/AMI12/models/spectre/allModels.scs" "")
)
analysis('tran ?stop "150n"  ?errpreset "moderate"  )
temp( 27 )
run()
selectResult( 'tran )
plot(getData("/INPUT") getData("/OUTPUT") )
modelFile(
    '("/auto/ee2/Cadence/local/designkits/BYU/lib/AMI12/models/spectre/allModels.scs" "")
)
run()
selectResult( 'tran )
plot(getData("/INPUT") getData("/OUTPUT") )
